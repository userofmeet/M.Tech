* NGSPICE file created from invx2_layout.ext - technology: sky130A

.subckt invx2_layout
X0 VOUT VIN VSS VSS sky130_fd_pr__nfet_01v8 ad=0.126 pd=1.02 as=0.126 ps=1.44 w=0.42 l=0.15
**devattr s=5040,288 d=5040,204
X1 VOUT VIN VDD VDD sky130_fd_pr__pfet_01v8 ad=0.378 pd=1.86 as=0.378 ps=3.12 w=1.26 l=0.15
**devattr s=15120,624 d=15120,372
X2 VSS VIN VOUT VSS sky130_fd_pr__nfet_01v8 ad=0.126 pd=1.44 as=0.126 ps=1.02 w=0.42 l=0.15
**devattr s=5040,204 d=5040,288
X3 VDD VIN VOUT VDD sky130_fd_pr__pfet_01v8 ad=0.378 pd=3.12 as=0.378 ps=1.86 w=1.26 l=0.15
**devattr s=15120,372 d=15120,624
C0 VDD VIN 0.18594f
C1 VOUT VIN 0.08794f
C2 VDD VOUT 0.2387f
C3 VOUT VSS 0.378f
C4 VDD VSS 0.81083f
.ends
