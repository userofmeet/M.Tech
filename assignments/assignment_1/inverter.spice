* Skywater PDK Simple Inverter Testbench
* AS = AD = W * (2 * L)
* PS = PD = 2 * (W + 2 * L)

.lib /usr/local/share/pdk/sky130A/libs.tech/ngspice/sky130.lib.spice tt

* driver inverter
XM1 vout vin vdd vdd sky130_fd_pr__pfet_01v8 l=0.15 w=0.84 as=0.252 ad=0.252 ps=2.28 pd=2.28
XM2 vout vin 0 0 sky130_fd_pr__nfet_01v8 l=0.15 w=0.42 as=0.126 ad=0.126 ps=1.44 pd=1.44

* load inverter
XM3 n1 vout vdd vdd sky130_fd_pr__pfet_01v8 l=0.15 w=0.84 as=0.252 ad=0.252 ps=2.28 pd=2.28
XM4 n1 vout 0 0 sky130_fd_pr__nfet_01v8 l=0.15 w=0.42 as=0.126 ad=0.126 ps=1.44 pd=1.44

* voltage source
VDD vdd 0 DC 1.8
vin vin 0 PULSE(0 1.8 0 20p 20p 500p 1n)

* transient analysis
.tran 1p 5n

* rise time
.measure tran tr TRIG v(vout) VAL=0.18 RISE=1 TARG v(vout) VAL=1.62 RISE=1

* fall time
.measure tran tf TRIG v(vout) VAL=1.62 FALL=1 TARG v(vout) VAL=0.18 FALL=1

* output goes form low to high
.measure tran tplh TRIG v(vin) VAL=0.9 FALL=1 TARG v(vout) VAL=0.9 RISE=1

* output goes from high to low
.measure tran tphl TRIG v(vin) VAL=0.9 RISE=1 TARG v(vout) VAL=0.9 FALL=1

* delay time
.measure tran tp PARAM = '(tphl+tplh)/2'

.control
run
plot v(vin) v(vout)
.endc
.end
