* Skywater PDK Simple Inverter Testbench
* Geometric Formulas:
* as = W * 2 * L
* ad = W * 2 * L
* ps = 2 * (W + 2 * L)
* pd = 2 * (W + 2 * L)

.lib /usr/local/share/pdk/sky130A/libs.tech/ngspice/sky130.lib.spice tt

* inverter 1
XM1 vout vin vdd vdd sky130_fd_pr__pfet_01v8 l=0.15 w=0.84
XM2 vout vin 0   0   sky130_fd_pr__nfet_01v8 l=0.15 w=0.42

XM3 n1 vout vdd vdd sky130_fd_pr__pfet_01v8 l=0.15 w=0.84
XM4 n1 vout 0   0   sky130_fd_pr__nfet_01v8 l=0.15 w=0.42

VDD vdd 0 DC 1.8
VIN vin 0 PULSE(0 1.8 0 20p 20p 500p 1n)

.tran 1p 5n
.measure tran tr   TRIG v(vout) VAL=0.18 RISE=1 TARG v(vout) VAL=1.62 RISE=1
.measure tran tf   TRIG v(vout) VAL=1.62 FALL=1 TARG v(vout) VAL=0.18 FALL=1
.measure tran tplh TRIG v(vin)  VAL=0.9 FALL=1 TARG v(vout) VAL=0.9 RISE=1
.measure tran tphl TRIG v(vin)  VAL=0.9 RISE=1 TARG v(vout) VAL=0.9 FALL=1
.measure tran tp PARAM='(tphl+tplh)/2'

.control
run
plot v(vin) v(vout)
.endc
